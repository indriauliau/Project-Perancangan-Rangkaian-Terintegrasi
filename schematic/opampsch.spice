** sch_path: /foss/designs/opampsch
**.subckt opampsch VINP VDD VOUT VSS VINN
*.ipin VINP
*.iopin VDD
*.opin VOUT
*.iopin VSS
*.ipin VINN
XC1 net4 VOUT sky130_fd_pr__cap_mim_m3_1 W=2.8 L=2.8 MF=1
XM0 net3 net3 VSS VSS sky130_fd_pr__nfet_01v8 L=0.18 W=4 nf=2 ad=0.58 as=1.16 pd=4.58 ps=9.16 nrd=0.0725 nrs=0.0725 sa=0 sb=0 sd=0
+ mult=1
XM1 net1 VINP net2 VSS sky130_fd_pr__nfet_01v8 L=0.18 W=150 nf=30 ad=21.75 as=23.2 pd=158.7 ps=169.28 nrd=0.00193333333333333
+ nrs=0.00193333333333333 sa=0 sb=0 sd=0 mult=1
XM2 net4 VINN net2 VSS sky130_fd_pr__nfet_01v8 L=0.18 W=150 nf=30 ad=21.75 as=23.2 pd=158.7 ps=169.28 nrd=0.00193333333333333
+ nrs=0.00193333333333333 sa=0 sb=0 sd=0 mult=1
XM3 net1 net1 VDD VDD sky130_fd_pr__pfet_01v8 L=0.18 W=4 nf=1 ad=1.16 as=1.16 pd=8.58 ps=8.58 nrd=0.0725 nrs=0.0725 sa=0 sb=0 sd=0
+ mult=1
XM4 net4 net1 VDD VDD sky130_fd_pr__pfet_01v8 L=0.18 W=4 nf=2 ad=0.58 as=1.16 pd=4.58 ps=9.16 nrd=0.0725 nrs=0.0725 sa=0 sb=0 sd=0
+ mult=1
XM5 net2 net3 VSS VSS sky130_fd_pr__nfet_01v8 L=0.18 W=4 nf=2 ad=0.58 as=1.16 pd=4.58 ps=9.16 nrd=0.0725 nrs=0.0725 sa=0 sb=0 sd=0
+ mult=1
XM6 VOUT net4 VDD VDD sky130_fd_pr__pfet_01v8 L=0.18 W=4 nf=2 ad=0.58 as=1.16 pd=4.58 ps=9.16 nrd=0.0725 nrs=0.0725 sa=0 sb=0 sd=0
+ mult=1
XM7 VOUT net3 VSS VSS sky130_fd_pr__nfet_01v8 L=0.18 W=4 nf=2 ad=0.58 as=1.16 pd=4.58 ps=9.16 nrd=0.0725 nrs=0.0725 sa=0 sb=0 sd=0
+ mult=1
XR1 net3 VDD VSS sky130_fd_pr__res_high_po_0p35 L=0.826 mult=1
**.ends
.end
